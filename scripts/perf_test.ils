; perf_test.ils - Performance tests

procedure(vaiElapsedMs(m)
    if(and(listp(m) numberp(nth(2 m)))
        1000.0 * nth(2 m)
        1000.0 * (car(m) + cadr(m))
    )
)

procedure(report(name cnt elapsed)
    let((per)
        per = float(elapsed) / float(cnt)
        printf("%-20s %8d  %8.3f ms  %10.6f ms/op\n" name cnt elapsed per)
    )
)

; Test 1: List cons
procedure(test_cons(n)
    let((r)
        r = nil
        report("List cons" n vaiElapsedMs(measureTime(progn(
        for(i 1 n
            r = cons(i r)
        )
        ))))
    )
)

; Test 2: List append
procedure(test_append(n)
    let((r)
        r = nil
        report("List append" n vaiElapsedMs(measureTime(progn(
        for(i 1 n
            r = append(r list(i))
        )
        ))))
    )
)

; Test 3: Hash lookup
procedure(test_hash(n)
    let((ht v)
        ht = makeTable("t" nil)
        for(i 1 n
            ht[i] = i
        )
        v = 0
        report("Hash lookup" n vaiElapsedMs(measureTime(progn(
        for(i 1 n
            v = ht[i]
        )
        ))))
    )
)

; Test 4: List nth
procedure(test_nth(n)
    let((r v)
        r = nil
        for(i 1 n
            r = cons(i r)
        )
        v = 0
        report("List nth" 50 vaiElapsedMs(measureTime(progn(
        for(i 1 50
            v = car(nth(i r))
        )
        ))))
    )
)

; Test 5: String concat
procedure(test_strcat(n)
    let((s)
        s = ""
        report("Strcat" n vaiElapsedMs(measureTime(progn(
        for(i 1 n
            s = strcat(s "x")
        )
        ))))
    )
)

; Test 6: Eval string
procedure(test_evalstr(n)
    let((v)
        report("Evalstring" n vaiElapsedMs(measureTime(progn(
        for(i 1 n
            v = evalstring(sprintf(nil "%d+1" i))
        )
        ))))
    )
)

printf("\n=== SKILL PERFORMANCE TESTS ===\n\n")

test_cons(5000)
test_append(500)
test_hash(5000)
test_nth(5000)
test_strcat(200)
test_evalstr(20)

printf("\n=== DONE ===\n")
